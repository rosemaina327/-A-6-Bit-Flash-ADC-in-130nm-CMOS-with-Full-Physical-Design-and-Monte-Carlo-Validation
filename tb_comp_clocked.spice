** sch_path: /home/master/Documents/6_bit_Flash_ADC/tb_comp_clocked.sch
**.subckt tb_comp_clocked
x1 VDD REG_P REG_N VSS strongarm_core
x2 PTAIL VDD REG_N REG_P VIP VIN VSS NTAIL strongarm_input
VDD VDD 0 1.8
VSS VSS 0 0
VIN VIN 0 0.9
VIP VIP 0 0.91
VCLK CLK 0 PULSE(0 1.8 0 100p 100p 5n 10n)
C1 REG_N 0 10f
C2 REG_P 0 10f
x4 VDD CLK NCLK REG_N VSS REG_P strongarm_precharge
x3 NTAIL VDD NCLK CLK PTAIL VSS strongarm_clock
**** begin user architecture code

* param VCM=0.9
* param VOD=10m

* Clock: 100MHz, 50% duty cycle
* PULSE(V1 V2 TD TR TF PW PER)

* Input signals
* VIN VIN 0 {VCM}
* VIP VIP 0 {VCM + VOD}

* Initial conditions - start at metastable point
.ic V(REG_N)=0.9 V(REG_P)=0.9

* Transient simulation
.tran 10p 50n uic

* Measure propagation delay from CLK rising to output decision
.measure tran TPD trig v(CLK) val=0.9 rise=1
+           targ v(REG_P) val=0.9 fall=1

* Measure power consumption
.measure tran PWR avg I(VDD)*1.8 from=20n to=50n

.control
run
plot V(CLK) V(VIN) V(VIP) V(REG_N) V(REG_P)
plot V(REG_N)-V(REG_P)
plot I(VDD)
.endc

.end

** opencircuitdesign pdks install
.lib /home/master/pdk/share/pdk/sky130A/libs.tech/combined/sky130.lib.spice tt

**** end user architecture code
**.ends

* expanding   symbol:  /home/master/Documents/6_bit_Flash_ADC/strongarm_core.sym # of pins=4
** sym_path: /home/master/Documents/6_bit_Flash_ADC/strongarm_core.sym
** sch_path: /home/master/Documents/6_bit_Flash_ADC/strongarm_core.sch
.subckt strongarm_core VDD REG_P REG_N VSS
*.ipin VDD
*.ipin VSS
*.opin REG_P
*.opin REG_N
XM8 REG_P REG_N VDD VDD sky130_fd_pr__pfet_01v8 L=0.15 W=12 nf=1 ad=3.48 as=3.48 pd=24.58 ps=24.58 nrd=0.0241666666666667
+ nrs=0.0241666666666667 sa=0 sb=0 sd=0 mult=1
XM6 REG_P REG_N VSS VSS sky130_fd_pr__nfet_01v8 L=0.15 W=6 nf=1 ad=1.74 as=1.74 pd=12.58 ps=12.58 nrd=0.0483333333333333
+ nrs=0.0483333333333333 sa=0 sb=0 sd=0 mult=1
XM5 REG_N REG_P VSS VSS sky130_fd_pr__nfet_01v8 L=0.15 W=6 nf=1 ad=1.74 as=1.74 pd=12.58 ps=12.58 nrd=0.0483333333333333
+ nrs=0.0483333333333333 sa=0 sb=0 sd=0 mult=1
XM7 REG_N REG_P VDD VDD sky130_fd_pr__pfet_01v8 L=0.15 W=12 nf=1 ad=3.48 as=3.48 pd=24.58 ps=24.58 nrd=0.0241666666666667
+ nrs=0.0241666666666667 sa=0 sb=0 sd=0 mult=1
.ends

* expanding   symbol:  /home/master/Documents/6_bit_Flash_ADC/strongarm_input.sym # of pins=8
** sym_path: /home/master/Documents/6_bit_Flash_ADC/strongarm_input.sym
** sch_path: /home/master/Documents/6_bit_Flash_ADC/strongarm_input.sch
.subckt strongarm_input PTAIL VDD REG_N REG_P VIP VIN VSS NTAIL
*.ipin PTAIL
*.ipin NTAIL
*.iopin REG_P
*.iopin REG_N
*.ipin VSS
*.ipin VDD
*.ipin VIP
*.ipin VIN
XM1 REG_N VIN NTAIL VSS sky130_fd_pr__nfet_01v8 L=0.15 W=12 nf=2 ad=1.74 as=3.48 pd=12.58 ps=25.16 nrd=0.0241666666666667
+ nrs=0.0241666666666667 sa=0 sb=0 sd=0 mult=1
XM2 REG_P VIP NTAIL VSS sky130_fd_pr__nfet_01v8 L=0.15 W=12 nf=2 ad=1.74 as=3.48 pd=12.58 ps=25.16 nrd=0.0241666666666667
+ nrs=0.0241666666666667 sa=0 sb=0 sd=0 mult=1
XM3 REG_N VIN PTAIL VDD sky130_fd_pr__pfet_01v8 L=0.15 W=24 nf=2 ad=3.48 as=6.96 pd=24.58 ps=49.16 nrd=0.0120833333333333
+ nrs=0.0120833333333333 sa=0 sb=0 sd=0 mult=1
XM4 REG_P VIP PTAIL VDD sky130_fd_pr__pfet_01v8 L=0.15 W=24 nf=2 ad=3.48 as=6.96 pd=24.58 ps=49.16 nrd=0.0120833333333333
+ nrs=0.0120833333333333 sa=0 sb=0 sd=0 mult=1
.ends

* expanding   symbol:  /home/master/Documents/6_bit_Flash_ADC/strongarm_precharge.sym # of pins=6
** sym_path: /home/master/Documents/6_bit_Flash_ADC/strongarm_precharge.sym
** sch_path: /home/master/Documents/6_bit_Flash_ADC/strongarm_precharge.sch
.subckt strongarm_precharge VDD CLK NCLK REG_N VSS REG_P
*.ipin CLK
*.ipin NCLK
*.ipin REG_N
*.ipin REG_P
*.ipin VDD
*.ipin VSS
XMP1 REG_N NCLK VDD VDD sky130_fd_pr__pfet_01v8 L=0.15 W=2 nf=1 ad=0.58 as=0.58 pd=4.58 ps=4.58 nrd=0.145 nrs=0.145 sa=0 sb=0 sd=0
+ mult=1
XMP2 REG_P NCLK VDD VDD sky130_fd_pr__pfet_01v8 L=0.15 W=2 nf=1 ad=0.58 as=0.58 pd=4.58 ps=4.58 nrd=0.145 nrs=0.145 sa=0 sb=0 sd=0
+ mult=1
XMN1 REG_N CLK VSS VSS sky130_fd_pr__nfet_01v8 L=0.15 W=1 nf=1 ad=0.29 as=0.29 pd=2.58 ps=2.58 nrd=0.29 nrs=0.29 sa=0 sb=0 sd=0
+ mult=1
XMN2 REG_P CLK VSS VSS sky130_fd_pr__nfet_01v8 L=0.15 W=1 nf=1 ad=0.29 as=0.29 pd=2.58 ps=2.58 nrd=0.29 nrs=0.29 sa=0 sb=0 sd=0
+ mult=1
.ends

* expanding   symbol:  /home/master/Documents/6_bit_Flash_ADC/strongarm_clock.sym # of pins=6
** sym_path: /home/master/Documents/6_bit_Flash_ADC/strongarm_clock.sym
** sch_path: /home/master/Documents/6_bit_Flash_ADC/strongarm_clock.sch
.subckt strongarm_clock NTAIL VDD NCLK CLK PTAIL VSS
*.ipin CLK
*.opin NCLK
*.opin NTAIL
*.opin PTAIL
*.ipin VDD
*.ipin VSS
XM10 PTAIL NCLK VDD VDD sky130_fd_pr__pfet_01v8 L=0.15 W=32 nf=4 ad=4.64 as=6.96 pd=33.16 ps=49.74 nrd=0.0090625 nrs=0.0090625
+ sa=0 sb=0 sd=0 mult=1
XM9 NTAIL CLK VSS VSS sky130_fd_pr__nfet_01v8 L=0.15 W=16 nf=4 ad=2.32 as=3.48 pd=17.16 ps=25.74 nrd=0.018125 nrs=0.018125 sa=0
+ sb=0 sd=0 mult=1
XMp NCLK CLK VDD VDD sky130_fd_pr__pfet_01v8 L=0.15 W=4 nf=1 ad=1.16 as=1.16 pd=8.58 ps=8.58 nrd=0.0725 nrs=0.0725 sa=0 sb=0 sd=0
+ mult=1
XMn NCLK CLK VSS VSS sky130_fd_pr__nfet_01v8 L=0.15 W=2 nf=1 ad=0.58 as=0.58 pd=4.58 ps=4.58 nrd=0.145 nrs=0.145 sa=0 sb=0 sd=0
+ mult=1
.ends

.end
